* ladder 340
vin n0 0 pulse(0 1 0 1n 1n 5n 10n)
r1 n0 n1 1
c1 n1 0 1f
r2 n1 n2 1
c2 n2 0 1f
r3 n2 n3 1
c3 n3 0 1f
r4 n3 n4 1
c4 n4 0 1f
r5 n4 n5 1
c5 n5 0 1f
r6 n5 n6 1
c6 n6 0 1f
r7 n6 n7 1
c7 n7 0 1f
r8 n7 n8 1
c8 n8 0 1f
r9 n8 n9 1
c9 n9 0 1f
r10 n9 n10 1
c10 n10 0 1f
r11 n10 n11 1
c11 n11 0 1f
r12 n11 n12 1
c12 n12 0 1f
r13 n12 n13 1
c13 n13 0 1f
r14 n13 n14 1
c14 n14 0 1f
r15 n14 n15 1
c15 n15 0 1f
r16 n15 n16 1
c16 n16 0 1f
r17 n16 n17 1
c17 n17 0 1f
r18 n17 n18 1
c18 n18 0 1f
r19 n18 n19 1
c19 n19 0 1f
r20 n19 n20 1
c20 n20 0 1f
r21 n20 n21 1
c21 n21 0 1f
r22 n21 n22 1
c22 n22 0 1f
r23 n22 n23 1
c23 n23 0 1f
r24 n23 n24 1
c24 n24 0 1f
r25 n24 n25 1
c25 n25 0 1f
r26 n25 n26 1
c26 n26 0 1f
r27 n26 n27 1
c27 n27 0 1f
r28 n27 n28 1
c28 n28 0 1f
r29 n28 n29 1
c29 n29 0 1f
r30 n29 n30 1
c30 n30 0 1f
r31 n30 n31 1
c31 n31 0 1f
r32 n31 n32 1
c32 n32 0 1f
r33 n32 n33 1
c33 n33 0 1f
r34 n33 n34 1
c34 n34 0 1f
r35 n34 n35 1
c35 n35 0 1f
r36 n35 n36 1
c36 n36 0 1f
r37 n36 n37 1
c37 n37 0 1f
r38 n37 n38 1
c38 n38 0 1f
r39 n38 n39 1
c39 n39 0 1f
r40 n39 n40 1
c40 n40 0 1f
r41 n40 n41 1
c41 n41 0 1f
r42 n41 n42 1
c42 n42 0 1f
r43 n42 n43 1
c43 n43 0 1f
r44 n43 n44 1
c44 n44 0 1f
r45 n44 n45 1
c45 n45 0 1f
r46 n45 n46 1
c46 n46 0 1f
r47 n46 n47 1
c47 n47 0 1f
r48 n47 n48 1
c48 n48 0 1f
r49 n48 n49 1
c49 n49 0 1f
r50 n49 n50 1
c50 n50 0 1f
r51 n50 n51 1
c51 n51 0 1f
r52 n51 n52 1
c52 n52 0 1f
r53 n52 n53 1
c53 n53 0 1f
r54 n53 n54 1
c54 n54 0 1f
r55 n54 n55 1
c55 n55 0 1f
r56 n55 n56 1
c56 n56 0 1f
r57 n56 n57 1
c57 n57 0 1f
r58 n57 n58 1
c58 n58 0 1f
r59 n58 n59 1
c59 n59 0 1f
r60 n59 n60 1
c60 n60 0 1f
r61 n60 n61 1
c61 n61 0 1f
r62 n61 n62 1
c62 n62 0 1f
r63 n62 n63 1
c63 n63 0 1f
r64 n63 n64 1
c64 n64 0 1f
r65 n64 n65 1
c65 n65 0 1f
r66 n65 n66 1
c66 n66 0 1f
r67 n66 n67 1
c67 n67 0 1f
r68 n67 n68 1
c68 n68 0 1f
r69 n68 n69 1
c69 n69 0 1f
r70 n69 n70 1
c70 n70 0 1f
r71 n70 n71 1
c71 n71 0 1f
r72 n71 n72 1
c72 n72 0 1f
r73 n72 n73 1
c73 n73 0 1f
r74 n73 n74 1
c74 n74 0 1f
r75 n74 n75 1
c75 n75 0 1f
r76 n75 n76 1
c76 n76 0 1f
r77 n76 n77 1
c77 n77 0 1f
r78 n77 n78 1
c78 n78 0 1f
r79 n78 n79 1
c79 n79 0 1f
r80 n79 n80 1
c80 n80 0 1f
r81 n80 n81 1
c81 n81 0 1f
r82 n81 n82 1
c82 n82 0 1f
r83 n82 n83 1
c83 n83 0 1f
r84 n83 n84 1
c84 n84 0 1f
r85 n84 n85 1
c85 n85 0 1f
r86 n85 n86 1
c86 n86 0 1f
r87 n86 n87 1
c87 n87 0 1f
r88 n87 n88 1
c88 n88 0 1f
r89 n88 n89 1
c89 n89 0 1f
r90 n89 n90 1
c90 n90 0 1f
r91 n90 n91 1
c91 n91 0 1f
r92 n91 n92 1
c92 n92 0 1f
r93 n92 n93 1
c93 n93 0 1f
r94 n93 n94 1
c94 n94 0 1f
r95 n94 n95 1
c95 n95 0 1f
r96 n95 n96 1
c96 n96 0 1f
r97 n96 n97 1
c97 n97 0 1f
r98 n97 n98 1
c98 n98 0 1f
r99 n98 n99 1
c99 n99 0 1f
r100 n99 n100 1
c100 n100 0 1f
r101 n100 n101 1
c101 n101 0 1f
r102 n101 n102 1
c102 n102 0 1f
r103 n102 n103 1
c103 n103 0 1f
r104 n103 n104 1
c104 n104 0 1f
r105 n104 n105 1
c105 n105 0 1f
r106 n105 n106 1
c106 n106 0 1f
r107 n106 n107 1
c107 n107 0 1f
r108 n107 n108 1
c108 n108 0 1f
r109 n108 n109 1
c109 n109 0 1f
r110 n109 n110 1
c110 n110 0 1f
r111 n110 n111 1
c111 n111 0 1f
r112 n111 n112 1
c112 n112 0 1f
r113 n112 n113 1
c113 n113 0 1f
r114 n113 n114 1
c114 n114 0 1f
r115 n114 n115 1
c115 n115 0 1f
r116 n115 n116 1
c116 n116 0 1f
r117 n116 n117 1
c117 n117 0 1f
r118 n117 n118 1
c118 n118 0 1f
r119 n118 n119 1
c119 n119 0 1f
r120 n119 n120 1
c120 n120 0 1f
r121 n120 n121 1
c121 n121 0 1f
r122 n121 n122 1
c122 n122 0 1f
r123 n122 n123 1
c123 n123 0 1f
r124 n123 n124 1
c124 n124 0 1f
r125 n124 n125 1
c125 n125 0 1f
r126 n125 n126 1
c126 n126 0 1f
r127 n126 n127 1
c127 n127 0 1f
r128 n127 n128 1
c128 n128 0 1f
r129 n128 n129 1
c129 n129 0 1f
r130 n129 n130 1
c130 n130 0 1f
r131 n130 n131 1
c131 n131 0 1f
r132 n131 n132 1
c132 n132 0 1f
r133 n132 n133 1
c133 n133 0 1f
r134 n133 n134 1
c134 n134 0 1f
r135 n134 n135 1
c135 n135 0 1f
r136 n135 n136 1
c136 n136 0 1f
r137 n136 n137 1
c137 n137 0 1f
r138 n137 n138 1
c138 n138 0 1f
r139 n138 n139 1
c139 n139 0 1f
r140 n139 n140 1
c140 n140 0 1f
r141 n140 n141 1
c141 n141 0 1f
r142 n141 n142 1
c142 n142 0 1f
r143 n142 n143 1
c143 n143 0 1f
r144 n143 n144 1
c144 n144 0 1f
r145 n144 n145 1
c145 n145 0 1f
r146 n145 n146 1
c146 n146 0 1f
r147 n146 n147 1
c147 n147 0 1f
r148 n147 n148 1
c148 n148 0 1f
r149 n148 n149 1
c149 n149 0 1f
r150 n149 n150 1
c150 n150 0 1f
r151 n150 n151 1
c151 n151 0 1f
r152 n151 n152 1
c152 n152 0 1f
r153 n152 n153 1
c153 n153 0 1f
r154 n153 n154 1
c154 n154 0 1f
r155 n154 n155 1
c155 n155 0 1f
r156 n155 n156 1
c156 n156 0 1f
r157 n156 n157 1
c157 n157 0 1f
r158 n157 n158 1
c158 n158 0 1f
r159 n158 n159 1
c159 n159 0 1f
r160 n159 n160 1
c160 n160 0 1f
r161 n160 n161 1
c161 n161 0 1f
r162 n161 n162 1
c162 n162 0 1f
r163 n162 n163 1
c163 n163 0 1f
r164 n163 n164 1
c164 n164 0 1f
r165 n164 n165 1
c165 n165 0 1f
r166 n165 n166 1
c166 n166 0 1f
r167 n166 n167 1
c167 n167 0 1f
r168 n167 n168 1
c168 n168 0 1f
r169 n168 n169 1
c169 n169 0 1f
r170 n169 n170 1
c170 n170 0 1f
r171 n170 n171 1
c171 n171 0 1f
r172 n171 n172 1
c172 n172 0 1f
r173 n172 n173 1
c173 n173 0 1f
r174 n173 n174 1
c174 n174 0 1f
r175 n174 n175 1
c175 n175 0 1f
r176 n175 n176 1
c176 n176 0 1f
r177 n176 n177 1
c177 n177 0 1f
r178 n177 n178 1
c178 n178 0 1f
r179 n178 n179 1
c179 n179 0 1f
r180 n179 n180 1
c180 n180 0 1f
r181 n180 n181 1
c181 n181 0 1f
r182 n181 n182 1
c182 n182 0 1f
r183 n182 n183 1
c183 n183 0 1f
r184 n183 n184 1
c184 n184 0 1f
r185 n184 n185 1
c185 n185 0 1f
r186 n185 n186 1
c186 n186 0 1f
r187 n186 n187 1
c187 n187 0 1f
r188 n187 n188 1
c188 n188 0 1f
r189 n188 n189 1
c189 n189 0 1f
r190 n189 n190 1
c190 n190 0 1f
r191 n190 n191 1
c191 n191 0 1f
r192 n191 n192 1
c192 n192 0 1f
r193 n192 n193 1
c193 n193 0 1f
r194 n193 n194 1
c194 n194 0 1f
r195 n194 n195 1
c195 n195 0 1f
r196 n195 n196 1
c196 n196 0 1f
r197 n196 n197 1
c197 n197 0 1f
r198 n197 n198 1
c198 n198 0 1f
r199 n198 n199 1
c199 n199 0 1f
r200 n199 n200 1
c200 n200 0 1f
r201 n200 n201 1
c201 n201 0 1f
r202 n201 n202 1
c202 n202 0 1f
r203 n202 n203 1
c203 n203 0 1f
r204 n203 n204 1
c204 n204 0 1f
r205 n204 n205 1
c205 n205 0 1f
r206 n205 n206 1
c206 n206 0 1f
r207 n206 n207 1
c207 n207 0 1f
r208 n207 n208 1
c208 n208 0 1f
r209 n208 n209 1
c209 n209 0 1f
r210 n209 n210 1
c210 n210 0 1f
r211 n210 n211 1
c211 n211 0 1f
r212 n211 n212 1
c212 n212 0 1f
r213 n212 n213 1
c213 n213 0 1f
r214 n213 n214 1
c214 n214 0 1f
r215 n214 n215 1
c215 n215 0 1f
r216 n215 n216 1
c216 n216 0 1f
r217 n216 n217 1
c217 n217 0 1f
r218 n217 n218 1
c218 n218 0 1f
r219 n218 n219 1
c219 n219 0 1f
r220 n219 n220 1
c220 n220 0 1f
r221 n220 n221 1
c221 n221 0 1f
r222 n221 n222 1
c222 n222 0 1f
r223 n222 n223 1
c223 n223 0 1f
r224 n223 n224 1
c224 n224 0 1f
r225 n224 n225 1
c225 n225 0 1f
r226 n225 n226 1
c226 n226 0 1f
r227 n226 n227 1
c227 n227 0 1f
r228 n227 n228 1
c228 n228 0 1f
r229 n228 n229 1
c229 n229 0 1f
r230 n229 n230 1
c230 n230 0 1f
r231 n230 n231 1
c231 n231 0 1f
r232 n231 n232 1
c232 n232 0 1f
r233 n232 n233 1
c233 n233 0 1f
r234 n233 n234 1
c234 n234 0 1f
r235 n234 n235 1
c235 n235 0 1f
r236 n235 n236 1
c236 n236 0 1f
r237 n236 n237 1
c237 n237 0 1f
r238 n237 n238 1
c238 n238 0 1f
r239 n238 n239 1
c239 n239 0 1f
r240 n239 n240 1
c240 n240 0 1f
r241 n240 n241 1
c241 n241 0 1f
r242 n241 n242 1
c242 n242 0 1f
r243 n242 n243 1
c243 n243 0 1f
r244 n243 n244 1
c244 n244 0 1f
r245 n244 n245 1
c245 n245 0 1f
r246 n245 n246 1
c246 n246 0 1f
r247 n246 n247 1
c247 n247 0 1f
r248 n247 n248 1
c248 n248 0 1f
r249 n248 n249 1
c249 n249 0 1f
r250 n249 n250 1
c250 n250 0 1f
r251 n250 n251 1
c251 n251 0 1f
r252 n251 n252 1
c252 n252 0 1f
r253 n252 n253 1
c253 n253 0 1f
r254 n253 n254 1
c254 n254 0 1f
r255 n254 n255 1
c255 n255 0 1f
r256 n255 n256 1
c256 n256 0 1f
r257 n256 n257 1
c257 n257 0 1f
r258 n257 n258 1
c258 n258 0 1f
r259 n258 n259 1
c259 n259 0 1f
r260 n259 n260 1
c260 n260 0 1f
r261 n260 n261 1
c261 n261 0 1f
r262 n261 n262 1
c262 n262 0 1f
r263 n262 n263 1
c263 n263 0 1f
r264 n263 n264 1
c264 n264 0 1f
r265 n264 n265 1
c265 n265 0 1f
r266 n265 n266 1
c266 n266 0 1f
r267 n266 n267 1
c267 n267 0 1f
r268 n267 n268 1
c268 n268 0 1f
r269 n268 n269 1
c269 n269 0 1f
r270 n269 n270 1
c270 n270 0 1f
r271 n270 n271 1
c271 n271 0 1f
r272 n271 n272 1
c272 n272 0 1f
r273 n272 n273 1
c273 n273 0 1f
r274 n273 n274 1
c274 n274 0 1f
r275 n274 n275 1
c275 n275 0 1f
r276 n275 n276 1
c276 n276 0 1f
r277 n276 n277 1
c277 n277 0 1f
r278 n277 n278 1
c278 n278 0 1f
r279 n278 n279 1
c279 n279 0 1f
r280 n279 n280 1
c280 n280 0 1f
r281 n280 n281 1
c281 n281 0 1f
r282 n281 n282 1
c282 n282 0 1f
r283 n282 n283 1
c283 n283 0 1f
r284 n283 n284 1
c284 n284 0 1f
r285 n284 n285 1
c285 n285 0 1f
r286 n285 n286 1
c286 n286 0 1f
r287 n286 n287 1
c287 n287 0 1f
r288 n287 n288 1
c288 n288 0 1f
r289 n288 n289 1
c289 n289 0 1f
r290 n289 n290 1
c290 n290 0 1f
r291 n290 n291 1
c291 n291 0 1f
r292 n291 n292 1
c292 n292 0 1f
r293 n292 n293 1
c293 n293 0 1f
r294 n293 n294 1
c294 n294 0 1f
r295 n294 n295 1
c295 n295 0 1f
r296 n295 n296 1
c296 n296 0 1f
r297 n296 n297 1
c297 n297 0 1f
r298 n297 n298 1
c298 n298 0 1f
r299 n298 n299 1
c299 n299 0 1f
r300 n299 n300 1
c300 n300 0 1f
r301 n300 n301 1
c301 n301 0 1f
r302 n301 n302 1
c302 n302 0 1f
r303 n302 n303 1
c303 n303 0 1f
r304 n303 n304 1
c304 n304 0 1f
r305 n304 n305 1
c305 n305 0 1f
r306 n305 n306 1
c306 n306 0 1f
r307 n306 n307 1
c307 n307 0 1f
r308 n307 n308 1
c308 n308 0 1f
r309 n308 n309 1
c309 n309 0 1f
r310 n309 n310 1
c310 n310 0 1f
r311 n310 n311 1
c311 n311 0 1f
r312 n311 n312 1
c312 n312 0 1f
r313 n312 n313 1
c313 n313 0 1f
r314 n313 n314 1
c314 n314 0 1f
r315 n314 n315 1
c315 n315 0 1f
r316 n315 n316 1
c316 n316 0 1f
r317 n316 n317 1
c317 n317 0 1f
r318 n317 n318 1
c318 n318 0 1f
r319 n318 n319 1
c319 n319 0 1f
r320 n319 n320 1
c320 n320 0 1f
r321 n320 n321 1
c321 n321 0 1f
r322 n321 n322 1
c322 n322 0 1f
r323 n322 n323 1
c323 n323 0 1f
r324 n323 n324 1
c324 n324 0 1f
r325 n324 n325 1
c325 n325 0 1f
r326 n325 n326 1
c326 n326 0 1f
r327 n326 n327 1
c327 n327 0 1f
r328 n327 n328 1
c328 n328 0 1f
r329 n328 n329 1
c329 n329 0 1f
r330 n329 n330 1
c330 n330 0 1f
r331 n330 n331 1
c331 n331 0 1f
r332 n331 n332 1
c332 n332 0 1f
r333 n332 n333 1
c333 n333 0 1f
r334 n333 n334 1
c334 n334 0 1f
r335 n334 n335 1
c335 n335 0 1f
r336 n335 n336 1
c336 n336 0 1f
r337 n336 n337 1
c337 n337 0 1f
r338 n337 n338 1
c338 n338 0 1f
r339 n338 n339 1
c339 n339 0 1f
r340 n339 n340 1
c340 n340 0 1f
.option post=1 post_version=9601
.tran 1n 3n
.end
